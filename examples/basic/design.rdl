addrmap my_root {
    default regwidth = 32;
    default accesswidth = 32;

    regfile regfile_1_t {
        regfile sub_regfile_t {
            reg {
                field { sw=rw; } enable[0:0] = 1'b0;
                field { sw=rw; } mode[3:1] = 3'b0;
                field { sw=r; } status[7:4] = 4'h0;
            } example_reg @0x0;
        } sub_regfile @0x20;
    } regfile_1[2] @0x100 += 0x40;
};
